module full_adder_structural (
    input wire a,
    input wire b,
    input wire cin,
    output wire sum,
    output wire cout
);

    wire w1, w2, w3, w4, w5;
    xor (w1, a, b);
    xor (sum, w1, cin);
    and (w2, a, b);
    and (w3, b, cin);
    and (w4, a, cin);
    or (cout, w2, w3, w4);

endmodule
